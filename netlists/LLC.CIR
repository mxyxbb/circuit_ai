* 半桥 LLC 谐振变换器
* ─────────────────────────────────────────────────────
* 规格: Vin=400V, fsw=100kHz, Vout≈20V, Pout=200W
* 谐振参数: Lr=50uH, Cr=50nF → fr=1/(2π√(LrCr))≈100kHz
* 变压器匝比: n=10:1 → Vout = Vin/(2n) = 400/(2×10) = 20V
* 负载: Rload=2Ω (200W @ 20V)
* 死区: 0.2μs/边沿 (duty=0.48, T=10μs → dead=0.2μs)
*
* 节点编号:
*   0 - GND
*   1 - 直流母线正极 (+400V)
*   2 - 半桥中点 (方波 0~400V)
*   3 - 谐振电感 Lr 输出端
*   4 - 谐振电容 Cr 输出端 / 变压器初级正极
*   5 - S1 门极驱动
*   6 - S2 门极驱动
*   7 - 变压器次级上端
*   8 - 变压器次级下端
*   9 - 输出电压正极

* ── 输入 ──────────────────────────────────────────────
Vin    1  0  DC 400

* ── 半桥开关 (互补驱动, 死区0.2μs) ──────────────────────
S1     1  2  5  0         * 高侧 MOSFET: D=1, S=2, G=5, GRef=0
S2     2  0  6  0         * 低侧 MOSFET: D=2, S=0, G=6, GRef=0
D3     2  1
D4     0  2

* ── 谐振槽路 ──────────────────────────────────────────
Lr     2  3  50u          * 串联谐振电感 50μH
Cr     3  4  50n          * 串联谐振电容 50nF → fr≈100kHz
Lm     4  0  2000u         * 励磁电感 200μH (并联在变压器初级两端)

* ── 理想变压器 10:1 ────────────────────────────────────
* 初级: 节点4(+) 0(-), 匝数10
* 次级: 节点7(+) 8(-), 匝数1
TX1    4  0  7  8  8  9  turns1=10 turns2=1 turns3=1

* ── 次级全桥整流 ────────────────────────────────────────
*       +--D1-->--+
*  7 ---+         +--- 9 (Vout+)
*       +--<-D3---+
*                 |
*       +--D2-->--+
*  8 ---+         (Vout- = GND)
*       +--<-D4---+
D1     0  7               * 正半周上管: A=7, K=Vout+
D2     0  9               * 负半周上管: A=8, K=Vout+

* ── 输出滤波 ───────────────────────────────────────────
Cout   8  0  100u
Rload  8  0  2

* ── 互补门极驱动 ─────────────────────────────────────────
* Vdrv1: 0~4.8μs HIGH, 4.8~10μs LOW (S1高侧)
* Vdrv2: 延迟5μs, 5~9.8μs HIGH, 9.8~15μs LOW (S2低侧)
* → 死区: 4.8~5μs (0.2μs) 和 9.8~10μs (0.2μs)
Vdrv1  5  0  SQUARE freq=100k duty=0.43 Vhigh=12 Vlow=0
Vdrv2  6  0  SQUARE freq=100k duty=0.43 Vhigh=12 Vlow=0 tdelay=5u

.TRAN 10n 0.01
.PROBE V(2) V(4) V(5) V(6) V(8) I(Lr) I(Lm)
.END
